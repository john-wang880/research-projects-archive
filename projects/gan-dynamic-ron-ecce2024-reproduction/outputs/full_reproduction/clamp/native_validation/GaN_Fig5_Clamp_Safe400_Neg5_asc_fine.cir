* ${PROJECT_ROOT}\outputs\full_reproduction\clamp\GaN_Fig5_Clamp_Safe400_Neg5.asc
Vdut input 0 PWL(0 {VBUS} 1u {VBUS} 1.02u {VON} 2u {VON} 2.02u {VBUS} 3u {VBUS})
XXblocking input gate_block out STN1NK60Z
XXbtb_top out gate_top middle DMG2302UK
XXbtb_bot 0 gate_bot middle DMG2302UK
Dtvsp out P001 DTVS
Dtvsm 0 P001 DTVS
Rprobe out 0 1Meg
Cprobe out 0 {CPROBE}
Cstray out 0 5p
Vdrive_block drv_block out PWL(0 0 1.05u 0 1.06u 10 1.94u 10 1.95u 0 3u 0)
Rgate_block drv_block gate_block {RDRV}
Vdrive_btb drv_btb middle PWL(0 4.5 0.93u 4.5 0.94u 0 2.04u 0 2.05u 4.5 3u 4.5)
Rgate_top drv_btb gate_top 2
Rgate_bot drv_btb gate_bot 2
Rmid_leak middle 0 100Meg
.model D D
* Figure 5: editable physical clamp schematic
* GaN_Fig5_Clamp_Safe400_Neg5: official representative parts; not author BOM; matching wide_safe_400V_neg5V.cir
* Gate timing must prevent the BTB short from overlapping negative DUT voltage.
* Back-to-back shunt outside the measuring window
* Blocking gate referenced to measurement output
* Common-source gate drive: strong OFF clamp / explicit interlock
.include ../models/stn1nk60z.lib
.include ../models/DMG2302UK_official.lib
.param VBUS=400 VON=-5 RDRV=20 CPROBE=14p
.model DTVS D(Is=1p N=1.25 Rs=0.145 BV=7.3 IBV=1m Cjo=6p)
.tran 0 3u 0 0.05n
.options plotwinsize=0 reltol=1e-6 abstol=1e-11
.save V(input) V(out) V(gate_block,out) V(gate_top,middle) I(Vdut) I(Dtvsp) I(Dtvsm)
.meas TRAN output_peak MAX V(out) FROM 0.95u TO 1.7u
.meas TRAN output_min MIN V(out) FROM 0.95u TO 1.7u
.meas TRAN off_peak MAX V(out) FROM 1.9u TO 2.3u
.meas TRAN plateau AVG V(out) FROM 1.4u TO 1.8u
.backanno
.end
